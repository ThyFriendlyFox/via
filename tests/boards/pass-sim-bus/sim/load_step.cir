* deck: load-step U1
* templates/project/sim/load_step.cir with its values set for the fixture board of
* tests/boards/sim_bus.py. U1 is FIXREG, the fixture's own made-up regulator (sim/models/fixreg.lib),
* from 5 V; C1 and C2 are 1u. The load steps from 1 mA to the 100 mA ratings.json states for J2.1.
.include "models/fixreg.lib"
VIN in 0 DC 5
C1 in 0 1u
XU1 in 0 out FIXREG
C2 out 0 1u
ILOAD out 0 PWL(0 1m 1m 1m 1.001m 100m 2m 100m 2.001m 1m 3m 1m)
.tran 0.1u 3m
.control
run
meas tran v_light find v(out) at=0.999m
meas tran v_low min v(out) from=1m to=2m
meas tran v_high max v(out) from=2m to=3m
let undershoot = v_light - v_low
let overshoot = v_high - v_light
print v_light v_low undershoot overshoot
.endc
.end
