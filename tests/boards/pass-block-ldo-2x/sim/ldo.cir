ldo: the linear regulator block U1 (TLV75533PDRVR), written by tools/blocks_ldo.py
* U1 is drawn as what it does: its output holds 3.2505 V, the least of its nominal, 3.3 V,
* with its accuracy, 3.2505 V to 3.3495 V, where it dissipates the most; its input carries the
* load's current and its greatest ground current, 40 uA [TLV755P datasheet, SBVS320D, November 2017, revised September 2024].
* vout is drawn, not judged: no bound holds it, since the deck does not model U1's regulation.
* The input is the greatest, 5.25 V; the load is 200 mA, a current source.
* p_u1 is U1's input power less its output power: what its junction dissipates.
* sim/thermal.json names it, and the SIM gate holds the junction at each temperature of
* sim/corners.json.
* The sums:
*   U1: TLV75533PDBVR passed over: TJ = 30 C + 231.1 C/W x 400 mW = 122.44 C at the most ambient, over 85 C, the least of 85 C, 0.7 x 150 C and 150 C - 40 C (nasa-eee-inst-002, section M4, table 4, page 10 of 10, the column Linear/Mixed Signal and note 2) [TI SLVA079, equation 10, page 11; TI SLVA079, equation 11, page 11; TLV755P datasheet, SBVS320D, section 7.2.2.2, equations 6 and 7, page 20; theta_ja and junction_max of TLV755P datasheet, SBVS320D, November 2017, revised September 2024, p 4 and 5]
*   U1: TLV75533PDRVR regulates to VOUT(NOM) = 3.3 V, the 3.3 V asked; with its accuracy, 3.3 V x (1 +- 0.015) = 3.25 V to 3.35 V [TLV755P datasheet, SBVS320D, table 8-1, Device Nomenclature, page 23: xx in TLV755xxP is the nominal output, 33 = 3.3 V; section 5.5, Output accuracy, VOUT >= 1 V, -1.5 % to 1.5 %, page 5]
*   U1: the input, 4.75 V to 5.25 V, is within IN's 1.45 V to 5.5 V [TLV755P datasheet, SBVS320D, November 2017, revised September 2024, p 3, 4 and 5]
*   U1: IOUT of 200 mA, under 500 mA [TLV755P datasheet, SBVS320D, section 5.3, Recommended Operating Conditions, IOUT, page 4]
*   U1: VDO = 200 mA x 238 mV / 500 mA = 95.2 mV; VOUT(NOM) + VDO = 3.3 V + 95.2 mV = 3.395 V, under the least input, 4.75 V [TI SLVA079, equation 1, page 2; TLV755P datasheet, SBVS320D, section 5.5, VDO at IOUT = 500 mA and -40 C to 125 C, the row 3.3 V <= VOUT < 5.0 V, the column MAX, page 6; section 7.1.2, page 15: VDO scales linearly with the output current; table 6-1 and section 6.4.1, page 14: VIN > VOUT(NOM) + VDO]
*   U1: PD = (40 uA + 200 mA) x (5.25 V - 3.2505 V, the least output) = 400 mW [TI SLVA079, equation 11, page 11; TLV755P datasheet, SBVS320D, section 7.2.2.2, equations 6 and 7, page 20]
*   U1: TJ = 30 C + 100.2 C/W x 400 mW = 70.078 C at the most ambient, under 85 C, the least of 85 C, 0.7 x 150 C and 150 C - 40 C (nasa-eee-inst-002, section M4, table 4, page 10 of 10, the column Linear/Mixed Signal and note 2); PD(max) = (85 C - 30 C) / 100.2 C/W = 549 mW; theta_ja 100.2 C/W was measured on the high-k 2s2p board of JESD 51-7 (p 5): a 2s2p board gives a best case and a 1s0p board a typical one (SPRA953D, section 1.2, page 3); a board unlike the test board changes it (section 1.1, page 2) [TI SLVA079, equation 10, page 11; TI SLVA079, equation 11, page 11; TLV755P datasheet, SBVS320D, section 7.2.2.2, equations 6 and 7, page 20; theta_ja and junction_max of TLV755P datasheet, SBVS320D, November 2017, revised September 2024, p 4 and 5]
*   U1: TJ from the least ambient, 0 C, to 70.078 C, within TJ's -40 C to 125 C [TLV755P datasheet, SBVS320D, section 5.3, Recommended Operating Conditions, TJ, page 4]
*   C2: CL10A106KP8NNN, X5R, rated 10 V, keeps 0.436 of 10 uF at 3.35 V and 0.993 of it at 0 C to 30 C: 10 uF x 0.9 x 0.436 x 0.993 = 3.9 uF, over 470 nF; 10 uF is within 1 uF to 200 uF [TLV755P datasheet, SBVS320D, section 7.1.1, page 15, and table 4-1, note 1, page 3: the effective capacitance at the pin greater than 0.47 uF; section 5.3, Recommended Operating Conditions, COUT, page 4; section 7.1.1, page 15: X5R- and X7R-type ceramic capacitors]; its CSR is not judged: the datasheet gives no graph of a stable CSR; section 7.1.1, page 15, names X5R and X7R ceramics for their small change of ESR [TI SLVA079, equation 8, page 9]
*   C1: CL10A106KP8NNN, X5R, rated 10 V, keeps 0.267 of 10 uF at 5.25 V and 0.993 of it at 0 C to 30 C: 10 uF x 0.9 x 0.267 x 0.993 = 2.38 uF, over 470 nF; 10 uF is 1 uF or more [TLV755P datasheet, SBVS320D, table 4-1, note 1, page 3: the effective capacitance at the pin greater than 0.47 uF; section 5.3, Recommended Operating Conditions, CIN, page 4; section 7.1.1, page 15: X5R- and X7R-type ceramic capacitors]
VIN in 0 DC 5.25
BU1 reg 0 V=3.2505
VU1 reg out DC 0
FU1 in 0 VU1 1
IU1 in 0 DC 40u
ILOAD out 0 DC 0.2
.control
op
let iout = i(vu1)
let vout = v(out)
let p_u1 = -v(in) * i(vin) - v(out) * i(vu1)
print iout vout p_u1
.endc
.end
