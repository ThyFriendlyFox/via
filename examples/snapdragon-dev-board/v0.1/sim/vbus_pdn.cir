* VBUS, the 5 V input, as the TPS62130 (U2) draws from it: a USB-C charger behind its cable, and C1
* and C2 at the buck's input. The cable is an assumption: 0.5 to 1.5 m at about 0.75 uH a metre of
* loop (LCABLE 0.75u, 50 % either way in sim/corners.json); its resistance is held at 50 mOhm, the
* low end, which damps the least. C1 and C2 are GRM21BR61C106KE15L, 10 uF 16 V X5R: their 10 % and
* what X5R loses at 5 V of DC bias are taken as 50 % (sim/corners.json), with 5 mOhm of ESR each.
* A 1 A AC current into the input reads the rail's impedance in ohms.
* The buck holds its output's power, so its input is a negative resistance, -VIN^2 / PIN: at the
* module's 8.7 W boot peak (PDS-0007 Table 9), the RP2350's side 0.15 W and 90 % efficiency, with
* VIN at USB's 4.75 V low, -2.29 Ohm. The input's peak impedance under that keeps the pair stable.
VS src 0 DC 5
RCABLE src a 50m
LCABLE a vbus 0.75u
C1 vbus e1 10u
RE1 e1 0 5m
C2 vbus e2 10u
RE2 e2 0 5m
I1 0 vbus DC 0 AC 1
.control
ac dec 400 10 10Meg
meas ac z_peak max vm(vbus)
meas ac f_peak max_at vm(vbus)
meas ac z_floor find vm(vbus) at=10
let half = z_floor + (z_peak - z_floor) / sqrt(2)
meas ac f_lo when vm(vbus)=$&half rise=1
meas ac f_hi when vm(vbus)=$&half fall=1
let q_peak = f_peak / (f_hi - f_lo)
print z_peak f_peak q_peak
.endc
.end
