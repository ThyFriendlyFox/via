* The off-hook detector: RING returns to GND through R22 (47 ohm), and R23 (10k) with C24 (10n)
* brings that voltage to the ESP32's ADC (GPIO5).
* The dialer is on hook: at most 0.5 mA flows, the panel's own line monitor (the design's allowance).
ILOOP 0 ring DC 0.5m
R22 ring 0 47 tc1=100u
R23 ring adc 10k tc1=100u
C24 adc 0 10n
ILEAK 0 adc DC 1u
.control
op
let v_loop = v(adc)
print v_loop
.endc
.end
